# Ansys Electronics Desktop project, version 2025.2
materials:
  vacuum: permittivity=1
  solder: permittivity=1 permeability=1 conductivity=4100000
  copper: permeability=0.999991 conductivity=58000000
  Molding: permittivity=3.8 permeability=1 dielectric_loss_tangent=0.01
  SR1: permittivity=3.4 permeability=1 dielectric_loss_tangent=0.019
  GL102: permittivity=3.3 permeability=1 dielectric_loss_tangent=0.0044
  HL832NSF: permittivity=3.9 permeability=1 dielectric_loss_tangent=0.0065
  air: permittivity=1.0006 permeability=1.0000004
surface materials:
  Steel-oxidised-surface

design FCBGA_Differential_Pair_From_XML (HFSS, HFSS Terminal Network, model units mm)
options: Allow_Material_Override Calculate_Lossy_Dielectrics
variables:
  z_start = 0mm
  t_molding_layer = 0.45mm
  z_molding_layer_top = z_start
  t_SM_top_layer = 0.02mm
  z_SM_top_layer_top = z_molding_layer_top - t_molding_layer
  t_Cu1 = 0.015mm
  z_Cu1_top = z_SM_top_layer_top - t_SM_top_layer
  t_DRILL1_2 = 0.03mm
  z_DRILL1_2_top = z_Cu1_top - t_Cu1
  t_Cu2 = 0.015mm
  z_Cu2_top = z_DRILL1_2_top - t_DRILL1_2
  t_DRILL2_3 = 0.03mm
  z_DRILL2_3_top = z_Cu2_top - t_Cu2
  t_Cu3 = 0.015mm
  z_Cu3_top = z_DRILL2_3_top - t_DRILL2_3
  t_DRILL3_4 = 0.03mm
  z_DRILL3_4_top = z_Cu3_top - t_Cu3
  t_Cu4 = 0.015mm
  z_Cu4_top = z_DRILL3_4_top - t_DRILL3_4
  t_DRILL4_5 = 0.03mm
  z_DRILL4_5_top = z_Cu4_top - t_Cu4
  t_Cu5 = 0.015mm
  z_Cu5_top = z_DRILL4_5_top - t_DRILL4_5
  t_DRILL5_6 = 0.2mm
  z_DRILL5_6_top = z_Cu5_top - t_Cu5
  t_Cu6 = 0.015mm
  z_Cu6_top = z_DRILL5_6_top - t_DRILL5_6
  t_DRILL6_7 = 0.03mm
  z_DRILL6_7_top = z_Cu6_top - t_Cu6
  t_Cu7 = 0.015mm
  z_Cu7_top = z_DRILL6_7_top - t_DRILL6_7
  t_DRILL7_8 = 0.03mm
  z_DRILL7_8_top = z_Cu7_top - t_Cu7
  t_Cu8 = 0.015mm
  z_Cu8_top = z_DRILL7_8_top - t_DRILL7_8
  t_DRILL8_9 = 0.03mm
  z_DRILL8_9_top = z_Cu8_top - t_Cu8
  t_Cu9 = 0.015mm
  z_Cu9_top = z_DRILL8_9_top - t_DRILL8_9
  t_DRILL9_10 = 0.03mm
  z_DRILL9_10_top = z_Cu9_top - t_Cu9
  t_Cu10 = 0.015mm
  z_Cu10_top = z_DRILL9_10_top - t_DRILL9_10
  t_SM_BOTTOM = 0.02mm
  z_SM_BOTTOM_top = z_Cu10_top - t_Cu10
  Via_1_2_pad_diameter_up = 0.1mm
  Via_1_2_pad_diameter_down = 0.1mm
  Via_1_2_drill_diameter = 0.065mm
  Via_1_2_pitch = 0.185mm
  Via_1_2_antipad_diameter = 0.2mm
  Via_1_3_pitch = 0.185mm
  Via_1_3_antipad_diameter = 0.2mm
  Via_2_3_pad_diameter_up = 0.1mm
  Via_2_3_pad_diameter_down = 0.1mm
  Via_2_3_drill_diameter = 0.065mm
  Via_2_3_pitch = 0.185mm
  Via_2_3_antipad_diameter = 0.2mm
  Via_3_4_pad_diameter_up = 0.1mm
  Via_3_4_pad_diameter_down = 0.1mm
  Via_3_4_drill_diameter = 0.065mm
  Via_3_4_pitch = 0.242mm
  Via_3_4_antipad_diameter = 0.25mm
  Via_3_5_pitch = 0.242mm
  Via_3_5_antipad_diameter = 0.25mm
  Via_4_5_pad_diameter_up = 0.1mm
  Via_4_5_pad_diameter_down = 0.11mm
  Via_4_5_drill_diameter = 0.065mm
  Via_4_5_pitch = 0.242mm
  Via_4_5_antipad_diameter = 0.25mm
  Via_5_6_pad_diameter_up = 0.15mm
  Via_5_6_pad_diameter_down = 0.15mm
  Via_5_6_drill_diameter = 0.09mm
  Via_5_6_pitch = 0.4mm
  Via_5_6_antipad_diameter = 0.36mm
  Via_6_7_pad_diameter_up = 0.11mm
  Via_6_7_pad_diameter_down = 0.1mm
  Via_6_7_drill_diameter = 0.065mm
  Via_6_7_pitch = 0.252mm
  Via_6_7_antipad_diameter = 0.25mm
  Via_6_8_pitch = 0.252mm
  Via_6_8_antipad_diameter = 0.25mm
  Via_7_8_pad_diameter_up = 0.1mm
  Via_7_8_pad_diameter_down = 0.1mm
  Via_7_8_drill_diameter = 0.065mm
  Via_7_8_pitch = 0.252mm
  Via_7_8_antipad_diameter = 0.25mm
  Via_8_9_pad_diameter_up = 0.1mm
  Via_8_9_pad_diameter_down = 0.1mm
  Via_8_9_drill_diameter = 0.065mm
  Via_8_9_pitch = 0.242mm
  Via_8_9_antipad_diameter = 0.25mm
  Via_8_10_pitch = 0.242mm
  Via_8_10_antipad_diameter = 0.25mm
  Via_9_10_pad_diameter_up = 0.1mm
  Via_9_10_pad_diameter_down = 0.1mm
  Via_9_10_drill_diameter = 0.065mm
  Via_9_10_pitch = 0.242mm
  Via_9_10_antipad_diameter = 0.25mm
  ball_diameter = 0.3mm
  ball_pitch = 0.5mm
  ball_height = 0.2mm
  ball_pad_diameter = 0.35m
  ball_antipad_diameter = 0.608mm
  ball_radius = ball_diameter/2
  Cu1_trace_width = 0.036mm
  Cu1_trace_gap = 0.06mm
  Cu1_trace_space = 0.05mm
  Cu2_trace_width = 0.025mm
  Cu2_trace_gap = 0.05mm
  Cu2_trace_space = 0.05mm
  Cu3_trace_width = 0.025mm
  Cu3_trace_gap = 0.05mm
  Cu3_trace_space = 0.05mm
  Cu4_trace_width = 0.025mm
  Cu4_trace_gap = 0.05mm
  Cu4_trace_space = 0.05mm
  Cu5_trace_width = 0.025mm
  Cu5_trace_gap = 0.05mm
  Cu5_trace_space = 0.05mm
  Cu6_trace_width = 0.025mm
  Cu6_trace_gap = 0.05mm
  Cu6_trace_space = 0.05mm
  Cu7_trace_width = 0.025mm
  Cu7_trace_gap = 0.05mm
  Cu7_trace_space = 0.05mm
  Cu8_trace_width = 0.025mm
  Cu8_trace_gap = 0.05mm
  Cu8_trace_space = 0.05mm
  Cu9_trace_width = 0.025mm
  Cu9_trace_gap = 0.05mm
  Cu9_trace_space = 0.05mm
  Cu10_trace_width = 0.036mm
  Cu10_trace_gap = 0.06mm
  Cu10_trace_space = 0.05mm
  p_ball_x = -ball_pitch/2
  n_ball_x = ball_pitch/2
  y_ball = 0mm
  p_x_via8_10 = -Via_8_10_pitch/2
  n_x_via8_10 = Via_8_10_pitch/2
  p_x_via6_8 = -Via_6_8_pitch/2
  n_x_via6_8 = Via_6_8_pitch/2
  p_x_via5_6 = -Via_5_6_pitch/2
  n_x_via5_6 = Via_5_6_pitch/2
  p_x_via3_5 = -Via_3_5_pitch/2
  n_x_via3_5 = Via_3_5_pitch/2
  p_x_via1_3 = -Via_1_3_pitch/2
  n_x_via1_3 = Via_1_3_pitch/2
  cond_10_8 = (ball_pad_diameter/2 + Via_9_10_pad_diameter_down/2)^2 - (p_ball_x - p_x_via8_10)^2 >= 0
  y_via8_10 = y_ball + if(cond_10_8, sqrt((ball_pad_diameter/2 + Via_9_10_pad_diameter_down/2)^2 - (p_ball_x - p_x_via8_10)^2), 0)
  l_cu8_trace_fixed = 1/2*ball_antipad_diameter + 1/2*Via_5_6_pad_diameter_down
  y_via6_8_from_fixed_trace = y_via8_10 + l_cu8_trace_fixed
  cond_6_5 = (Via_6_7_pad_diameter_up/2 + Via_5_6_pad_diameter_down/2)^2 - (p_x_via6_8 - p_x_via5_6)^2 >= 0
  y_via5_6_if_fixed = y_via6_8_from_fixed_trace + if(cond_6_5, sqrt((Via_6_7_pad_diameter_up/2 + Via_5_6_pad_diameter_down/2)^2 - (p_x_via6_8 - p_x_via5_6)^2), 0)
  y_via5_6_min_clearance = (1/2*ball_antipad_diameter + 1/2*Via_5_6_pad_diameter_down) + Via_5_6_antipad_diameter/2
  y_via5_6 = max(y_via5_6_if_fixed, y_via5_6_min_clearance)
  y_via6_8 = y_via5_6 - if(cond_6_5, sqrt((Via_6_7_pad_diameter_up/2 + Via_5_6_pad_diameter_down/2)^2 - (p_x_via6_8 - p_x_via5_6)^2), 0)
  cond_5_3 = (Via_5_6_pad_diameter_up/2 + Via_4_5_pad_diameter_down/2)^2 - (p_x_via5_6 - p_x_via3_5)^2 >= 0
  y_via3_5 = y_via5_6 + if(cond_5_3, sqrt((Via_5_6_pad_diameter_up/2 + Via_4_5_pad_diameter_down/2)^2 - (p_x_via5_6 - p_x_via3_5)^2), 0)
  cond_3_1 = (Via_3_4_pad_diameter_up/2 + Via_2_3_pad_diameter_down/2)^2 - (p_x_via3_5 - p_x_via1_3)^2 >= 0
  y_via1_3 = y_via3_5 + if(cond_3_1, sqrt((Via_3_4_pad_diameter_up/2 + Via_2_3_pad_diameter_down/2)^2 - (p_x_via3_5 - p_x_via1_3)^2), 0)
  l_cu1_trace = 1mm
  y_cu1_end = y_via1_3 + l_cu1_trace
  model_x_margin = 0mm
  model_y_margin = 0mm
  gnd_x_max = ball_pitch*1.5 + ball_pad_diameter/2
  gnd_x_min = -gnd_x_max
  model_x_min = gnd_x_min - model_x_margin
  model_x_size = gnd_x_max - gnd_x_min + 2*model_x_margin
  model_y_min = -0.5mm
  model_y_max = y_cu1_end + model_y_margin
  model_y_size = model_y_max - model_y_min
  clearance_w_cu1 = 2*(Cu1_trace_width + Cu1_trace_space + Cu1_trace_gap)
  clearance_w_cu8 = 2*(Cu8_trace_width + Cu8_trace_space + Cu8_trace_gap)
geometry:
  P_Path [copper] = cylinder(axis=Z, base_centre=(p_ball_x, y_ball, z_Cu10_top), radius=ball_pad_diameter/2, height=-t_Cu10)
  N_Path [copper] = cylinder(axis=Z, base_centre=(n_ball_x, y_ball, z_Cu10_top), radius=ball_pad_diameter/2, height=-t_Cu10)
  P_Ball [solder] = cylinder(axis=Z, base_centre=(p_ball_x, y_ball, z_Cu10_top - t_Cu10), radius=ball_diameter/2, height=-ball_height)
  N_Ball [solder] = cylinder(axis=Z, base_centre=(n_ball_x, y_ball, z_Cu10_top - t_Cu10), radius=ball_diameter/2, height=-ball_height)
  GND_Ball_0 [solder] = cylinder(axis=Z, base_centre=(-ball_pitch*1.5, y_ball, z_Cu10_top - t_Cu10), radius=ball_diameter/2, height=-ball_height)
  GND_Ball_1 [solder] = cylinder(axis=Z, base_centre=(ball_pitch*1.5, y_ball, z_Cu10_top - t_Cu10), radius=ball_diameter/2, height=-ball_height)
  GND_Ball_2 [solder] = cylinder(axis=Z, base_centre=(-ball_pitch*1.5, y_ball + ball_pitch, z_Cu10_top - t_Cu10), radius=ball_diameter/2, height=-ball_height)
  GND_Ball_3 [solder] = cylinder(axis=Z, base_centre=(-ball_pitch*0.5, y_ball + ball_pitch, z_Cu10_top - t_Cu10), radius=ball_diameter/2, height=-ball_height)
  GND_Ball_4 [solder] = cylinder(axis=Z, base_centre=(ball_pitch*0.5, y_ball + ball_pitch, z_Cu10_top - t_Cu10), radius=ball_diameter/2, height=-ball_height)
  GND_Ball_5 [solder] = cylinder(axis=Z, base_centre=(ball_pitch*1.5, y_ball + ball_pitch, z_Cu10_top - t_Cu10), radius=ball_diameter/2, height=-ball_height)
  P_Via_8_10 = cylinder(axis=Z, base_centre=(p_x_via8_10, y_via8_10, z_Cu8_top), radius=Via_8_9_drill_diameter/2, height=-(z_Cu8_top - z_Cu9_top))
  P_Via_8_10_pad_up = cylinder(axis=Z, base_centre=(p_x_via8_10, y_via8_10, z_Cu8_top), radius=Via_8_9_pad_diameter_up/2, height=-t_Cu8)
  P_Via_8_10_pad_shared_0 = cylinder(axis=Z, base_centre=(p_x_via8_10, y_via8_10, z_Cu9_top), radius=Via_8_9_pad_diameter_down/2, height=-t_Cu9)
  P_Via_8_10_drill_1 = cylinder(axis=Z, base_centre=(p_x_via8_10, y_via8_10, z_Cu9_top), radius=Via_9_10_drill_diameter/2, height=-(z_Cu9_top - z_Cu10_top))
  P_Via_8_10_pad_shared_1 = cylinder(axis=Z, base_centre=(p_x_via8_10, y_via8_10, z_Cu10_top), radius=Via_9_10_pad_diameter_down/2, height=-t_Cu10)
  P_Via_8_10.unite(P_Via_8_10_pad_up, P_Via_8_10_pad_shared_0, P_Via_8_10_drill_1, P_Via_8_10_pad_shared_1)
  N_Via_8_10 = cylinder(axis=Z, base_centre=(n_x_via8_10, y_via8_10, z_Cu8_top), radius=Via_8_9_drill_diameter/2, height=-(z_Cu8_top - z_Cu9_top))
  N_Via_8_10_pad_up = cylinder(axis=Z, base_centre=(n_x_via8_10, y_via8_10, z_Cu8_top), radius=Via_8_9_pad_diameter_up/2, height=-t_Cu8)
  N_Via_8_10_pad_shared_0 = cylinder(axis=Z, base_centre=(n_x_via8_10, y_via8_10, z_Cu9_top), radius=Via_8_9_pad_diameter_down/2, height=-t_Cu9)
  N_Via_8_10_drill_1 = cylinder(axis=Z, base_centre=(n_x_via8_10, y_via8_10, z_Cu9_top), radius=Via_9_10_drill_diameter/2, height=-(z_Cu9_top - z_Cu10_top))
  N_Via_8_10_pad_shared_1 = cylinder(axis=Z, base_centre=(n_x_via8_10, y_via8_10, z_Cu10_top), radius=Via_9_10_pad_diameter_down/2, height=-t_Cu10)
  N_Via_8_10.unite(N_Via_8_10_pad_up, N_Via_8_10_pad_shared_0, N_Via_8_10_drill_1, N_Via_8_10_pad_shared_1)
  P_Via_6_8 = cylinder(axis=Z, base_centre=(p_x_via6_8, y_via6_8, z_Cu6_top), radius=Via_6_7_drill_diameter/2, height=-(z_Cu6_top - z_Cu7_top))
  P_Via_6_8_pad_up = cylinder(axis=Z, base_centre=(p_x_via6_8, y_via6_8, z_Cu6_top), radius=Via_6_7_pad_diameter_up/2, height=-t_Cu6)
  P_Via_6_8_pad_shared_0 = cylinder(axis=Z, base_centre=(p_x_via6_8, y_via6_8, z_Cu7_top), radius=Via_6_7_pad_diameter_down/2, height=-t_Cu7)
  P_Via_6_8_drill_1 = cylinder(axis=Z, base_centre=(p_x_via6_8, y_via6_8, z_Cu7_top), radius=Via_7_8_drill_diameter/2, height=-(z_Cu7_top - z_Cu8_top))
  P_Via_6_8_pad_shared_1 = cylinder(axis=Z, base_centre=(p_x_via6_8, y_via6_8, z_Cu8_top), radius=Via_7_8_pad_diameter_down/2, height=-t_Cu8)
  P_Via_6_8.unite(P_Via_6_8_pad_up, P_Via_6_8_pad_shared_0, P_Via_6_8_drill_1, P_Via_6_8_pad_shared_1)
  N_Via_6_8 = cylinder(axis=Z, base_centre=(n_x_via6_8, y_via6_8, z_Cu6_top), radius=Via_6_7_drill_diameter/2, height=-(z_Cu6_top - z_Cu7_top))
  N_Via_6_8_pad_up = cylinder(axis=Z, base_centre=(n_x_via6_8, y_via6_8, z_Cu6_top), radius=Via_6_7_pad_diameter_up/2, height=-t_Cu6)
  N_Via_6_8_pad_shared_0 = cylinder(axis=Z, base_centre=(n_x_via6_8, y_via6_8, z_Cu7_top), radius=Via_6_7_pad_diameter_down/2, height=-t_Cu7)
  N_Via_6_8_drill_1 = cylinder(axis=Z, base_centre=(n_x_via6_8, y_via6_8, z_Cu7_top), radius=Via_7_8_drill_diameter/2, height=-(z_Cu7_top - z_Cu8_top))
  N_Via_6_8_pad_shared_1 = cylinder(axis=Z, base_centre=(n_x_via6_8, y_via6_8, z_Cu8_top), radius=Via_7_8_pad_diameter_down/2, height=-t_Cu8)
  N_Via_6_8.unite(N_Via_6_8_pad_up, N_Via_6_8_pad_shared_0, N_Via_6_8_drill_1, N_Via_6_8_pad_shared_1)
  P_Via_5_6 = cylinder(axis=Z, base_centre=(p_x_via5_6, y_via5_6, z_Cu5_top), radius=Via_5_6_drill_diameter/2, height=-(z_Cu5_top - z_Cu6_top))
  P_Via_5_6_pad_up = cylinder(axis=Z, base_centre=(p_x_via5_6, y_via5_6, z_Cu5_top), radius=Via_5_6_pad_diameter_up/2, height=-t_Cu5)
  P_Via_5_6_pad_shared_0 = cylinder(axis=Z, base_centre=(p_x_via5_6, y_via5_6, z_Cu6_top), radius=Via_5_6_pad_diameter_down/2, height=-t_Cu6)
  P_Via_5_6.unite(P_Via_5_6_pad_up, P_Via_5_6_pad_shared_0)
  N_Via_5_6 = cylinder(axis=Z, base_centre=(n_x_via5_6, y_via5_6, z_Cu5_top), radius=Via_5_6_drill_diameter/2, height=-(z_Cu5_top - z_Cu6_top))
  N_Via_5_6_pad_up = cylinder(axis=Z, base_centre=(n_x_via5_6, y_via5_6, z_Cu5_top), radius=Via_5_6_pad_diameter_up/2, height=-t_Cu5)
  N_Via_5_6_pad_shared_0 = cylinder(axis=Z, base_centre=(n_x_via5_6, y_via5_6, z_Cu6_top), radius=Via_5_6_pad_diameter_down/2, height=-t_Cu6)
  N_Via_5_6.unite(N_Via_5_6_pad_up, N_Via_5_6_pad_shared_0)
  P_Via_3_5 = cylinder(axis=Z, base_centre=(p_x_via3_5, y_via3_5, z_Cu3_top), radius=Via_3_4_drill_diameter/2, height=-(z_Cu3_top - z_Cu4_top))
  P_Via_3_5_pad_up = cylinder(axis=Z, base_centre=(p_x_via3_5, y_via3_5, z_Cu3_top), radius=Via_3_4_pad_diameter_up/2, height=-t_Cu3)
  P_Via_3_5_pad_shared_0 = cylinder(axis=Z, base_centre=(p_x_via3_5, y_via3_5, z_Cu4_top), radius=Via_3_4_pad_diameter_down/2, height=-t_Cu4)
  P_Via_3_5_drill_1 = cylinder(axis=Z, base_centre=(p_x_via3_5, y_via3_5, z_Cu4_top), radius=Via_4_5_drill_diameter/2, height=-(z_Cu4_top - z_Cu5_top))
  P_Via_3_5_pad_shared_1 = cylinder(axis=Z, base_centre=(p_x_via3_5, y_via3_5, z_Cu5_top), radius=Via_4_5_pad_diameter_down/2, height=-t_Cu5)
  P_Via_3_5.unite(P_Via_3_5_pad_up, P_Via_3_5_pad_shared_0, P_Via_3_5_drill_1, P_Via_3_5_pad_shared_1)
  N_Via_3_5 = cylinder(axis=Z, base_centre=(n_x_via3_5, y_via3_5, z_Cu3_top), radius=Via_3_4_drill_diameter/2, height=-(z_Cu3_top - z_Cu4_top))
  N_Via_3_5_pad_up = cylinder(axis=Z, base_centre=(n_x_via3_5, y_via3_5, z_Cu3_top), radius=Via_3_4_pad_diameter_up/2, height=-t_Cu3)
  N_Via_3_5_pad_shared_0 = cylinder(axis=Z, base_centre=(n_x_via3_5, y_via3_5, z_Cu4_top), radius=Via_3_4_pad_diameter_down/2, height=-t_Cu4)
  N_Via_3_5_drill_1 = cylinder(axis=Z, base_centre=(n_x_via3_5, y_via3_5, z_Cu4_top), radius=Via_4_5_drill_diameter/2, height=-(z_Cu4_top - z_Cu5_top))
  N_Via_3_5_pad_shared_1 = cylinder(axis=Z, base_centre=(n_x_via3_5, y_via3_5, z_Cu5_top), radius=Via_4_5_pad_diameter_down/2, height=-t_Cu5)
  N_Via_3_5.unite(N_Via_3_5_pad_up, N_Via_3_5_pad_shared_0, N_Via_3_5_drill_1, N_Via_3_5_pad_shared_1)
  P_Via_1_3 = cylinder(axis=Z, base_centre=(p_x_via1_3, y_via1_3, z_Cu1_top), radius=Via_1_2_drill_diameter/2, height=-(z_Cu1_top - z_Cu2_top))
  P_Via_1_3_pad_up = cylinder(axis=Z, base_centre=(p_x_via1_3, y_via1_3, z_Cu1_top), radius=Via_1_2_pad_diameter_up/2, height=-t_Cu1)
  P_Via_1_3_pad_shared_0 = cylinder(axis=Z, base_centre=(p_x_via1_3, y_via1_3, z_Cu2_top), radius=Via_1_2_pad_diameter_down/2, height=-t_Cu2)
  P_Via_1_3_drill_1 = cylinder(axis=Z, base_centre=(p_x_via1_3, y_via1_3, z_Cu2_top), radius=Via_2_3_drill_diameter/2, height=-(z_Cu2_top - z_Cu3_top))
  P_Via_1_3_pad_shared_1 = cylinder(axis=Z, base_centre=(p_x_via1_3, y_via1_3, z_Cu3_top), radius=Via_2_3_pad_diameter_down/2, height=-t_Cu3)
  P_Via_1_3.unite(P_Via_1_3_pad_up, P_Via_1_3_pad_shared_0, P_Via_1_3_drill_1, P_Via_1_3_pad_shared_1)
  N_Via_1_3 = cylinder(axis=Z, base_centre=(n_x_via1_3, y_via1_3, z_Cu1_top), radius=Via_1_2_drill_diameter/2, height=-(z_Cu1_top - z_Cu2_top))
  N_Via_1_3_pad_up = cylinder(axis=Z, base_centre=(n_x_via1_3, y_via1_3, z_Cu1_top), radius=Via_1_2_pad_diameter_up/2, height=-t_Cu1)
  N_Via_1_3_pad_shared_0 = cylinder(axis=Z, base_centre=(n_x_via1_3, y_via1_3, z_Cu2_top), radius=Via_1_2_pad_diameter_down/2, height=-t_Cu2)
  N_Via_1_3_drill_1 = cylinder(axis=Z, base_centre=(n_x_via1_3, y_via1_3, z_Cu2_top), radius=Via_2_3_drill_diameter/2, height=-(z_Cu2_top - z_Cu3_top))
  N_Via_1_3_pad_shared_1 = cylinder(axis=Z, base_centre=(n_x_via1_3, y_via1_3, z_Cu3_top), radius=Via_2_3_pad_diameter_down/2, height=-t_Cu3)
  N_Via_1_3.unite(N_Via_1_3_pad_up, N_Via_1_3_pad_shared_0, N_Via_1_3_drill_1, N_Via_1_3_pad_shared_1)
  P_Trace_Cu10_conn = polyline((p_x_via8_10, y_via8_10, (z_Cu10_top) - (t_Cu10/2)) (p_ball_x, y_ball, (z_Cu10_top) - (t_Cu10/2)), section rectangle width=Cu10_trace_width height=t_Cu10)
  N_Trace_Cu10_conn = polyline((n_x_via8_10, y_via8_10, (z_Cu10_top) - (t_Cu10/2)) (n_ball_x, y_ball, (z_Cu10_top) - (t_Cu10/2)), section rectangle width=Cu10_trace_width height=t_Cu10)
  P_Trace_Cu6_conn = polyline((p_x_via5_6, y_via5_6, (z_Cu6_top) - (t_Cu6/2)) (p_x_via6_8, y_via6_8, (z_Cu6_top) - (t_Cu6/2)), section rectangle width=Cu6_trace_width height=t_Cu6)
  N_Trace_Cu6_conn = polyline((n_x_via5_6, y_via5_6, (z_Cu6_top) - (t_Cu6/2)) (n_x_via6_8, y_via6_8, (z_Cu6_top) - (t_Cu6/2)), section rectangle width=Cu6_trace_width height=t_Cu6)
  P_Trace_Cu5_conn = polyline((p_x_via3_5, y_via3_5, (z_Cu5_top) - (t_Cu5/2)) (p_x_via5_6, y_via5_6, (z_Cu5_top) - (t_Cu5/2)), section rectangle width=Cu5_trace_width height=t_Cu5)
  N_Trace_Cu5_conn = polyline((n_x_via3_5, y_via3_5, (z_Cu5_top) - (t_Cu5/2)) (n_x_via5_6, y_via5_6, (z_Cu5_top) - (t_Cu5/2)), section rectangle width=Cu5_trace_width height=t_Cu5)
  P_Trace_Cu3_conn = polyline((p_x_via1_3, y_via1_3, (z_Cu3_top) - (t_Cu3/2)) (p_x_via3_5, y_via3_5, (z_Cu3_top) - (t_Cu3/2)), section rectangle width=Cu3_trace_width height=t_Cu3)
  N_Trace_Cu3_conn = polyline((n_x_via1_3, y_via1_3, (z_Cu3_top) - (t_Cu3/2)) (n_x_via3_5, y_via3_5, (z_Cu3_top) - (t_Cu3/2)), section rectangle width=Cu3_trace_width height=t_Cu3)
  P_Trace_Cu8 = polyline(z=(z_Cu8_top) - (t_Cu8/2), xy: (p_x_via8_10, y_via8_10) (-((Cu8_trace_gap/2) + (Cu8_trace_width/2)), y_via8_10 + abs(-((Cu8_trace_gap/2) + (Cu8_trace_width/2)) - (p_x_via8_10))) (-((Cu8_trace_gap/2) + (Cu8_trace_width/2)), y_via6_8 - abs(p_x_via6_8 - (-((Cu8_trace_gap/2) + (Cu8_trace_width/2))))) (p_x_via6_8, y_via6_8), section rectangle width=Cu8_trace_width height=t_Cu8)
  N_Trace_Cu8 = polyline(z=(z_Cu8_top) - (t_Cu8/2), xy: (n_x_via8_10, y_via8_10) (((Cu8_trace_gap/2) + (Cu8_trace_width/2)), y_via8_10 + abs(((Cu8_trace_gap/2) + (Cu8_trace_width/2)) - (n_x_via8_10))) (((Cu8_trace_gap/2) + (Cu8_trace_width/2)), y_via6_8 - abs(n_x_via6_8 - (((Cu8_trace_gap/2) + (Cu8_trace_width/2))))) (n_x_via6_8, y_via6_8), section rectangle width=Cu8_trace_width height=t_Cu8)
  P_Trace_Cu1 = polyline(z=(z_Cu1_top) - (t_Cu1/2), xy: (p_x_via1_3, y_via1_3) (-((Cu1_trace_gap/2) + (Cu1_trace_width/2)), y_via1_3 + abs(-((Cu1_trace_gap/2) + (Cu1_trace_width/2)) - (p_x_via1_3))) (-((Cu1_trace_gap/2) + (Cu1_trace_width/2)), y_via1_3 + l_cu1_trace), section rectangle width=Cu1_trace_width height=t_Cu1)
  N_Trace_Cu1 = polyline(z=(z_Cu1_top) - (t_Cu1/2), xy: (n_x_via1_3, y_via1_3) (((Cu1_trace_gap/2) + (Cu1_trace_width/2)), y_via1_3 + abs(((Cu1_trace_gap/2) + (Cu1_trace_width/2)) - (n_x_via1_3))) (((Cu1_trace_gap/2) + (Cu1_trace_width/2)), y_via1_3 + l_cu1_trace), section rectangle width=Cu1_trace_width height=t_Cu1)
  P_Path.unite(P_Via_8_10, P_Via_6_8, P_Via_5_6, P_Via_3_5, P_Via_1_3, P_Trace_Cu10_conn, P_Trace_Cu6_conn, P_Trace_Cu5_conn, P_Trace_Cu3_conn, P_Trace_Cu8, P_Trace_Cu1)
  N_Path.unite(N_Via_8_10, N_Via_6_8, N_Via_5_6, N_Via_3_5, N_Via_1_3, N_Trace_Cu10_conn, N_Trace_Cu6_conn, N_Trace_Cu5_conn, N_Trace_Cu3_conn, N_Trace_Cu8, N_Trace_Cu1)
  molding_layer [Molding] = box(corner=(model_x_min, model_y_min, z_molding_layer_top), size=(model_x_size, model_y_size, -(t_molding_layer)))
  SM_top_layer [SR1] = box(corner=(model_x_min, model_y_min, z_SM_top_layer_top), size=(model_x_size, model_y_size, -(t_SM_top_layer)))
  Cu1 [copper] = box(corner=(model_x_min, -0.3mm, z_Cu1_top), size=(model_x_size, model_y_max - (-0.3mm), -(t_Cu1)))
  Filling_Cu1 [SR1] = box(corner=(model_x_min, model_y_min, z_Cu1_top), size=(model_x_size, model_y_size, -(t_Cu1)))
  DRILL1_2 [GL102] = box(corner=(model_x_min, model_y_min, z_DRILL1_2_top), size=(model_x_size, model_y_size, -(t_DRILL1_2)))
  Cu2 [copper] = box(corner=(model_x_min, -0.3mm, z_Cu2_top), size=(model_x_size, model_y_max - (-0.3mm), -(t_Cu2)))
  Filling_Cu2 [GL102] = box(corner=(model_x_min, model_y_min, z_Cu2_top), size=(model_x_size, model_y_size, -(t_Cu2)))
  DRILL2_3 [GL102] = box(corner=(model_x_min, model_y_min, z_DRILL2_3_top), size=(model_x_size, model_y_size, -(t_DRILL2_3)))
  Cu3 [copper] = box(corner=(model_x_min, -0.3mm, z_Cu3_top), size=(model_x_size, model_y_max - (-0.3mm), -(t_Cu3)))
  Filling_Cu3 [GL102] = box(corner=(model_x_min, model_y_min, z_Cu3_top), size=(model_x_size, model_y_size, -(t_Cu3)))
  DRILL3_4 [GL102] = box(corner=(model_x_min, model_y_min, z_DRILL3_4_top), size=(model_x_size, model_y_size, -(t_DRILL3_4)))
  Cu4 [copper] = box(corner=(model_x_min, -0.3mm, z_Cu4_top), size=(model_x_size, model_y_max - (-0.3mm), -(t_Cu4)))
  Filling_Cu4 [GL102] = box(corner=(model_x_min, model_y_min, z_Cu4_top), size=(model_x_size, model_y_size, -(t_Cu4)))
  DRILL4_5 [GL102] = box(corner=(model_x_min, model_y_min, z_DRILL4_5_top), size=(model_x_size, model_y_size, -(t_DRILL4_5)))
  Cu5 [copper] = box(corner=(model_x_min, -0.3mm, z_Cu5_top), size=(model_x_size, model_y_max - (-0.3mm), -(t_Cu5)))
  Filling_Cu5 [GL102] = box(corner=(model_x_min, model_y_min, z_Cu5_top), size=(model_x_size, model_y_size, -(t_Cu5)))
  DRILL5_6 [HL832NSF] = box(corner=(model_x_min, model_y_min, z_DRILL5_6_top), size=(model_x_size, model_y_size, -(t_DRILL5_6)))
  Cu6 [copper] = box(corner=(model_x_min, -0.3mm, z_Cu6_top), size=(model_x_size, model_y_max - (-0.3mm), -(t_Cu6)))
  Filling_Cu6 [GL102] = box(corner=(model_x_min, model_y_min, z_Cu6_top), size=(model_x_size, model_y_size, -(t_Cu6)))
  DRILL6_7 [GL102] = box(corner=(model_x_min, model_y_min, z_DRILL6_7_top), size=(model_x_size, model_y_size, -(t_DRILL6_7)))
  Cu7 [copper] = box(corner=(model_x_min, -0.3mm, z_Cu7_top), size=(model_x_size, model_y_max - (-0.3mm), -(t_Cu7)))
  Filling_Cu7 [GL102] = box(corner=(model_x_min, model_y_min, z_Cu7_top), size=(model_x_size, model_y_size, -(t_Cu7)))
  DRILL7_8 [GL102] = box(corner=(model_x_min, model_y_min, z_DRILL7_8_top), size=(model_x_size, model_y_size, -(t_DRILL7_8)))
  Cu8 [copper] = box(corner=(model_x_min, -0.3mm, z_Cu8_top), size=(model_x_size, model_y_max - (-0.3mm), -(t_Cu8)))
  Filling_Cu8 [GL102] = box(corner=(model_x_min, model_y_min, z_Cu8_top), size=(model_x_size, model_y_size, -(t_Cu8)))
  DRILL8_9 [GL102] = box(corner=(model_x_min, model_y_min, z_DRILL8_9_top), size=(model_x_size, model_y_size, -(t_DRILL8_9)))
  Cu9 [copper] = box(corner=(model_x_min, -0.3mm, z_Cu9_top), size=(model_x_size, model_y_max - (-0.3mm), -(t_Cu9)))
  Filling_Cu9 [GL102] = box(corner=(model_x_min, model_y_min, z_Cu9_top), size=(model_x_size, model_y_size, -(t_Cu9)))
  DRILL9_10 [GL102] = box(corner=(model_x_min, model_y_min, z_DRILL9_10_top), size=(model_x_size, model_y_size, -(t_DRILL9_10)))
  Cu10 [copper] = box(corner=(model_x_min, -0.3mm, z_Cu10_top), size=(model_x_size, model_y_max - (-0.3mm), -(t_Cu10)))
  Filling_Cu10 [SR1] = box(corner=(model_x_min, model_y_min, z_Cu10_top), size=(model_x_size, model_y_size, -(t_Cu10)))
  SM_BOTTOM [SR1] = box(corner=(model_x_min, model_y_min, z_SM_BOTTOM_top), size=(model_x_size, model_y_size, -(t_SM_BOTTOM)))
  Antipad_Ball = cylinder(axis=Z, base_centre=(p_ball_x, y_ball, z_Cu3_top), radius=ball_antipad_diameter/2, height=-(z_Cu3_top - (z_Cu10_top - t_Cu10)))
  Antipad_Ball_n_cyl = cylinder(axis=Z, base_centre=(n_ball_x, y_ball, z_Cu3_top), radius=ball_antipad_diameter/2, height=-(z_Cu3_top - (z_Cu10_top - t_Cu10)))
  Antipad_Ball_box = box(corner=(p_ball_x, y_ball - ball_antipad_diameter/2, z_Cu3_top), size=(ball_pitch, ball_antipad_diameter, -(z_Cu3_top - (z_Cu10_top - t_Cu10))))
  Antipad_Ball.unite(Antipad_Ball_n_cyl, Antipad_Ball_box)
  Antipad_Via_8_10 = cylinder(axis=Z, base_centre=(p_x_via8_10, y_via8_10, z_Cu8_top), radius=Via_8_10_antipad_diameter/2, height=-(z_Cu8_top - (z_Cu10_top - t_Cu10)))
  Antipad_Via_8_10_n_cyl = cylinder(axis=Z, base_centre=(n_x_via8_10, y_via8_10, z_Cu8_top), radius=Via_8_10_antipad_diameter/2, height=-(z_Cu8_top - (z_Cu10_top - t_Cu10)))
  Antipad_Via_8_10_box = box(corner=(p_x_via8_10, y_via8_10 - Via_8_10_antipad_diameter/2, z_Cu8_top), size=(Via_8_10_pitch, Via_8_10_antipad_diameter, -(z_Cu8_top - (z_Cu10_top - t_Cu10))))
  Antipad_Via_8_10.unite(Antipad_Via_8_10_n_cyl, Antipad_Via_8_10_box)
  Antipad_Via_6_8 = cylinder(axis=Z, base_centre=(p_x_via6_8, y_via6_8, z_Cu6_top), radius=Via_6_8_antipad_diameter/2, height=-(z_Cu6_top - (z_Cu8_top - t_Cu8)))
  Antipad_Via_6_8_n_cyl = cylinder(axis=Z, base_centre=(n_x_via6_8, y_via6_8, z_Cu6_top), radius=Via_6_8_antipad_diameter/2, height=-(z_Cu6_top - (z_Cu8_top - t_Cu8)))
  Antipad_Via_6_8_box = box(corner=(p_x_via6_8, y_via6_8 - Via_6_8_antipad_diameter/2, z_Cu6_top), size=(Via_6_8_pitch, Via_6_8_antipad_diameter, -(z_Cu6_top - (z_Cu8_top - t_Cu8))))
  Antipad_Via_6_8.unite(Antipad_Via_6_8_n_cyl, Antipad_Via_6_8_box)
  Antipad_Via_5_6 = cylinder(axis=Z, base_centre=(p_x_via5_6, y_via5_6, z_Cu4_top), radius=Via_5_6_antipad_diameter/2, height=-(z_Cu4_top - (z_Cu7_top - t_Cu7)))
  Antipad_Via_5_6_n_cyl = cylinder(axis=Z, base_centre=(n_x_via5_6, y_via5_6, z_Cu4_top), radius=Via_5_6_antipad_diameter/2, height=-(z_Cu4_top - (z_Cu7_top - t_Cu7)))
  Antipad_Via_5_6_box = box(corner=(p_x_via5_6, y_via5_6 - Via_5_6_antipad_diameter/2, z_Cu4_top), size=(Via_5_6_pitch, Via_5_6_antipad_diameter, -(z_Cu4_top - (z_Cu7_top - t_Cu7))))
  Antipad_Via_5_6.unite(Antipad_Via_5_6_n_cyl, Antipad_Via_5_6_box)
  Antipad_Via_3_5 = cylinder(axis=Z, base_centre=(p_x_via3_5, y_via3_5, z_Cu3_top), radius=Via_3_5_antipad_diameter/2, height=-(z_Cu3_top - (z_Cu5_top - t_Cu5)))
  Antipad_Via_3_5_n_cyl = cylinder(axis=Z, base_centre=(n_x_via3_5, y_via3_5, z_Cu3_top), radius=Via_3_5_antipad_diameter/2, height=-(z_Cu3_top - (z_Cu5_top - t_Cu5)))
  Antipad_Via_3_5_box = box(corner=(p_x_via3_5, y_via3_5 - Via_3_5_antipad_diameter/2, z_Cu3_top), size=(Via_3_5_pitch, Via_3_5_antipad_diameter, -(z_Cu3_top - (z_Cu5_top - t_Cu5))))
  Antipad_Via_3_5.unite(Antipad_Via_3_5_n_cyl, Antipad_Via_3_5_box)
  Antipad_Via_1_3 = cylinder(axis=Z, base_centre=(p_x_via1_3, y_via1_3, z_Cu1_top), radius=Via_1_3_antipad_diameter/2, height=-(z_Cu1_top - (z_Cu3_top - t_Cu3)))
  Antipad_Via_1_3_n_cyl = cylinder(axis=Z, base_centre=(n_x_via1_3, y_via1_3, z_Cu1_top), radius=Via_1_3_antipad_diameter/2, height=-(z_Cu1_top - (z_Cu3_top - t_Cu3)))
  Antipad_Via_1_3_box = box(corner=(p_x_via1_3, y_via1_3 - Via_1_3_antipad_diameter/2, z_Cu1_top), size=(Via_1_3_pitch, Via_1_3_antipad_diameter, -(z_Cu1_top - (z_Cu3_top - t_Cu3))))
  Antipad_Via_1_3.unite(Antipad_Via_1_3_n_cyl, Antipad_Via_1_3_box)
  Clearance_Cu1 = box(corner=(-clearance_w_cu1/2, y_via1_3, z_Cu1_top), size=(clearance_w_cu1, l_cu1_trace, -t_Cu1))
  Clearance_Cu8 = box(corner=(-clearance_w_cu8/2, y_via8_10, z_Cu8_top), size=(clearance_w_cu8, y_via6_8 - y_via8_10, -t_Cu8))
  Antipad_Ball_1 = Antipad_Ball.copy()
  Antipad_Via_8_10_1 = Antipad_Via_8_10.copy()
  Antipad_Via_6_8_1 = Antipad_Via_6_8.copy()
  Antipad_Via_5_6_1 = Antipad_Via_5_6.copy()
  Antipad_Via_3_5_1 = Antipad_Via_3_5.copy()
  Antipad_Via_1_3_1 = Antipad_Via_1_3.copy()
  Clearance_Cu1_1 = Clearance_Cu1.copy()
  Clearance_Cu8_1 = Clearance_Cu8.copy()
  Cu1.subtract(Antipad_Ball_1, Antipad_Via_8_10_1, Antipad_Via_6_8_1, Antipad_Via_5_6_1, Antipad_Via_3_5_1, Antipad_Via_1_3_1, Clearance_Cu1_1, Clearance_Cu8_1)
  Antipad_Ball_2 = Antipad_Ball.copy()
  Antipad_Via_8_10_2 = Antipad_Via_8_10.copy()
  Antipad_Via_6_8_2 = Antipad_Via_6_8.copy()
  Antipad_Via_5_6_2 = Antipad_Via_5_6.copy()
  Antipad_Via_3_5_2 = Antipad_Via_3_5.copy()
  Antipad_Via_1_3_2 = Antipad_Via_1_3.copy()
  Clearance_Cu1_2 = Clearance_Cu1.copy()
  Clearance_Cu8_2 = Clearance_Cu8.copy()
  Cu2.subtract(Antipad_Ball_2, Antipad_Via_8_10_2, Antipad_Via_6_8_2, Antipad_Via_5_6_2, Antipad_Via_3_5_2, Antipad_Via_1_3_2, Clearance_Cu1_2, Clearance_Cu8_2)
  Antipad_Ball_3 = Antipad_Ball.copy()
  Antipad_Via_8_10_3 = Antipad_Via_8_10.copy()
  Antipad_Via_6_8_3 = Antipad_Via_6_8.copy()
  Antipad_Via_5_6_3 = Antipad_Via_5_6.copy()
  Antipad_Via_3_5_3 = Antipad_Via_3_5.copy()
  Antipad_Via_1_3_3 = Antipad_Via_1_3.copy()
  Clearance_Cu1_3 = Clearance_Cu1.copy()
  Clearance_Cu8_3 = Clearance_Cu8.copy()
  Cu3.subtract(Antipad_Ball_3, Antipad_Via_8_10_3, Antipad_Via_6_8_3, Antipad_Via_5_6_3, Antipad_Via_3_5_3, Antipad_Via_1_3_3, Clearance_Cu1_3, Clearance_Cu8_3)
  Antipad_Ball_4 = Antipad_Ball.copy()
  Antipad_Via_8_10_4 = Antipad_Via_8_10.copy()
  Antipad_Via_6_8_4 = Antipad_Via_6_8.copy()
  Antipad_Via_5_6_4 = Antipad_Via_5_6.copy()
  Antipad_Via_3_5_4 = Antipad_Via_3_5.copy()
  Antipad_Via_1_3_4 = Antipad_Via_1_3.copy()
  Clearance_Cu1_4 = Clearance_Cu1.copy()
  Clearance_Cu8_4 = Clearance_Cu8.copy()
  Cu4.subtract(Antipad_Ball_4, Antipad_Via_8_10_4, Antipad_Via_6_8_4, Antipad_Via_5_6_4, Antipad_Via_3_5_4, Antipad_Via_1_3_4, Clearance_Cu1_4, Clearance_Cu8_4)
  Antipad_Ball_5 = Antipad_Ball.copy()
  Antipad_Via_8_10_5 = Antipad_Via_8_10.copy()
  Antipad_Via_6_8_5 = Antipad_Via_6_8.copy()
  Antipad_Via_5_6_5 = Antipad_Via_5_6.copy()
  Antipad_Via_3_5_5 = Antipad_Via_3_5.copy()
  Antipad_Via_1_3_5 = Antipad_Via_1_3.copy()
  Clearance_Cu1_5 = Clearance_Cu1.copy()
  Clearance_Cu8_5 = Clearance_Cu8.copy()
  Cu5.subtract(Antipad_Ball_5, Antipad_Via_8_10_5, Antipad_Via_6_8_5, Antipad_Via_5_6_5, Antipad_Via_3_5_5, Antipad_Via_1_3_5, Clearance_Cu1_5, Clearance_Cu8_5)
  Antipad_Ball_6 = Antipad_Ball.copy()
  Antipad_Via_8_10_6 = Antipad_Via_8_10.copy()
  Antipad_Via_6_8_6 = Antipad_Via_6_8.copy()
  Antipad_Via_5_6_6 = Antipad_Via_5_6.copy()
  Antipad_Via_3_5_6 = Antipad_Via_3_5.copy()
  Antipad_Via_1_3_6 = Antipad_Via_1_3.copy()
  Clearance_Cu1_6 = Clearance_Cu1.copy()
  Clearance_Cu8_6 = Clearance_Cu8.copy()
  Cu6.subtract(Antipad_Ball_6, Antipad_Via_8_10_6, Antipad_Via_6_8_6, Antipad_Via_5_6_6, Antipad_Via_3_5_6, Antipad_Via_1_3_6, Clearance_Cu1_6, Clearance_Cu8_6)
  Antipad_Ball_7 = Antipad_Ball.copy()
  Antipad_Via_8_10_7 = Antipad_Via_8_10.copy()
  Antipad_Via_6_8_7 = Antipad_Via_6_8.copy()
  Antipad_Via_5_6_7 = Antipad_Via_5_6.copy()
  Antipad_Via_3_5_7 = Antipad_Via_3_5.copy()
  Antipad_Via_1_3_7 = Antipad_Via_1_3.copy()
  Clearance_Cu1_7 = Clearance_Cu1.copy()
  Clearance_Cu8_7 = Clearance_Cu8.copy()
  Cu7.subtract(Antipad_Ball_7, Antipad_Via_8_10_7, Antipad_Via_6_8_7, Antipad_Via_5_6_7, Antipad_Via_3_5_7, Antipad_Via_1_3_7, Clearance_Cu1_7, Clearance_Cu8_7)
  Antipad_Ball_8 = Antipad_Ball.copy()
  Antipad_Via_8_10_8 = Antipad_Via_8_10.copy()
  Antipad_Via_6_8_8 = Antipad_Via_6_8.copy()
  Antipad_Via_5_6_8 = Antipad_Via_5_6.copy()
  Antipad_Via_3_5_8 = Antipad_Via_3_5.copy()
  Antipad_Via_1_3_8 = Antipad_Via_1_3.copy()
  Clearance_Cu1_8 = Clearance_Cu1.copy()
  Clearance_Cu8_8 = Clearance_Cu8.copy()
  Cu8.subtract(Antipad_Ball_8, Antipad_Via_8_10_8, Antipad_Via_6_8_8, Antipad_Via_5_6_8, Antipad_Via_3_5_8, Antipad_Via_1_3_8, Clearance_Cu1_8, Clearance_Cu8_8)
  Antipad_Ball_9 = Antipad_Ball.copy()
  Antipad_Via_8_10_9 = Antipad_Via_8_10.copy()
  Antipad_Via_6_8_9 = Antipad_Via_6_8.copy()
  Antipad_Via_5_6_9 = Antipad_Via_5_6.copy()
  Antipad_Via_3_5_9 = Antipad_Via_3_5.copy()
  Antipad_Via_1_3_9 = Antipad_Via_1_3.copy()
  Clearance_Cu1_9 = Clearance_Cu1.copy()
  Clearance_Cu8_9 = Clearance_Cu8.copy()
  Cu9.subtract(Antipad_Ball_9, Antipad_Via_8_10_9, Antipad_Via_6_8_9, Antipad_Via_5_6_9, Antipad_Via_3_5_9, Antipad_Via_1_3_9, Clearance_Cu1_9, Clearance_Cu8_9)
  Cu10.subtract(Antipad_Ball, Antipad_Via_8_10, Antipad_Via_6_8, Antipad_Via_5_6, Antipad_Via_3_5, Antipad_Via_1_3, Clearance_Cu1, Clearance_Cu8)
  Port_Sheet_Cu1 = rectangle(corner=(-(2 * (2*Cu1_trace_width + Cu1_trace_gap + 2*Cu1_trace_space))/2, y_cu1_end, z_Cu2_top), z_size=2 * (t_SM_top_layer + t_DRILL1_2), x_size=2 * (2*Cu1_trace_width + Cu1_trace_gap + 2*Cu1_trace_space))
  BGA_GND_Sheet = rectangle(corner=(-ball_pitch*1.5 - ball_diameter/2, ball_pitch + ball_diameter/2, (z_Cu10_top - t_Cu10) - ball_height), x_size=3*ball_pitch + ball_diameter, y_size=-ball_pitch - ball_diameter - 0.3mm)
  P_Port_Sheet_BGA = circle(normal=Z, centre=(p_ball_x, y_ball, (z_Cu10_top - t_Cu10) - ball_height), radius=1.1 * ball_radius)
  N_Port_Sheet_BGA = circle(normal=Z, centre=(n_ball_x, y_ball, (z_Cu10_top - t_Cu10) - ball_height), radius=1.1 * ball_radius)
  P_Port_Sheet_BGA_1 = P_Port_Sheet_BGA.copy()
  N_Port_Sheet_BGA_1 = N_Port_Sheet_BGA.copy()
  BGA_GND_Sheet.subtract(P_Port_Sheet_BGA_1, N_Port_Sheet_BGA_1)
  Region [air] = region(absolute_offset: +X=3mm, -X=3mm, +Y=0mm, -Y=3mm, +Z=3mm, -Z=3mm)
  Return_Path_DRILL1_2 [copper] = object_from(Cu1.face(-z))
  Cu2_ObjectFromFace1 = object_from(Cu2.face(+z))
  Return_Path_DRILL1_2.sweep_along_vector((0mm, 0mm, -t_DRILL1_2))
  Cu2_ObjectFromFace1.sweep_along_vector((0mm, 0mm, t_DRILL1_2))
  Return_Path_DRILL1_2.intersect(Cu2_ObjectFromFace1)
  Return_Path_DRILL2_3 [copper] = object_from(Cu2.face(-z))
  Cu3_ObjectFromFace1 = object_from(Cu3.face(+z))
  Return_Path_DRILL2_3.sweep_along_vector((0mm, 0mm, -t_DRILL2_3))
  Cu3_ObjectFromFace1.sweep_along_vector((0mm, 0mm, t_DRILL2_3))
  Return_Path_DRILL2_3.intersect(Cu3_ObjectFromFace1)
  Return_Path_DRILL3_4 [copper] = object_from(Cu3.face(-z))
  Cu4_ObjectFromFace1 = object_from(Cu4.face(+z))
  Return_Path_DRILL3_4.sweep_along_vector((0mm, 0mm, -t_DRILL3_4))
  Cu4_ObjectFromFace1.sweep_along_vector((0mm, 0mm, t_DRILL3_4))
  Return_Path_DRILL3_4.intersect(Cu4_ObjectFromFace1)
  Return_Path_DRILL4_5 [copper] = object_from(Cu4.face(-z))
  Cu5_ObjectFromFace1 = object_from(Cu5.face(+z))
  Return_Path_DRILL4_5.sweep_along_vector((0mm, 0mm, -t_DRILL4_5))
  Cu5_ObjectFromFace1.sweep_along_vector((0mm, 0mm, t_DRILL4_5))
  Return_Path_DRILL4_5.intersect(Cu5_ObjectFromFace1)
  Return_Path_DRILL5_6 [copper] = object_from(Cu5.face(-z))
  Cu6_ObjectFromFace1 = object_from(Cu6.face(+z))
  Return_Path_DRILL5_6.sweep_along_vector((0mm, 0mm, -t_DRILL5_6))
  Cu6_ObjectFromFace1.sweep_along_vector((0mm, 0mm, t_DRILL5_6))
  Return_Path_DRILL5_6.intersect(Cu6_ObjectFromFace1)
  Return_Path_DRILL6_7 [copper] = object_from(Cu6.face(-z))
  Cu7_ObjectFromFace1 = object_from(Cu7.face(+z))
  Return_Path_DRILL6_7.sweep_along_vector((0mm, 0mm, -t_DRILL6_7))
  Cu7_ObjectFromFace1.sweep_along_vector((0mm, 0mm, t_DRILL6_7))
  Return_Path_DRILL6_7.intersect(Cu7_ObjectFromFace1)
  Return_Path_DRILL7_8 [copper] = object_from(Cu7.face(-z))
  Cu8_ObjectFromFace1 = object_from(Cu8.face(+z))
  Return_Path_DRILL7_8.sweep_along_vector((0mm, 0mm, -t_DRILL7_8))
  Cu8_ObjectFromFace1.sweep_along_vector((0mm, 0mm, t_DRILL7_8))
  Return_Path_DRILL7_8.intersect(Cu8_ObjectFromFace1)
  Return_Path_DRILL8_9 [copper] = object_from(Cu8.face(-z))
  Cu9_ObjectFromFace1 = object_from(Cu9.face(+z))
  Return_Path_DRILL8_9.sweep_along_vector((0mm, 0mm, -t_DRILL8_9))
  Cu9_ObjectFromFace1.sweep_along_vector((0mm, 0mm, t_DRILL8_9))
  Return_Path_DRILL8_9.intersect(Cu9_ObjectFromFace1)
  Return_Path_DRILL9_10 [copper] = object_from(Cu9.face(-z))
  Cu10_ObjectFromFace1 = object_from(Cu10.face(+z))
  Return_Path_DRILL9_10.sweep_along_vector((0mm, 0mm, -t_DRILL9_10))
  Cu10_ObjectFromFace1.sweep_along_vector((0mm, 0mm, t_DRILL9_10))
  Return_Path_DRILL9_10.intersect(Cu10_ObjectFromFace1)
boundaries and excitations:
  PerfE_GG6CLR: Perfect E Objects=BGA_GND_Sheet
  Rad__JSIRS3: Radiation Objects=Region
  P_Path_T1: Terminal port=P1 Faces=P_Path.face(at (-0.048, 1.86933, -0.4775)) TerminalResistance=50ohm
  N_Path_T1: Terminal port=P1 Faces=N_Path.face(at (0.048, 1.86933, -0.4775)) TerminalResistance=50ohm
  P2_BGA_P_T1: Terminal port=P2_BGA_P Faces=P_Ball.face(-z end) TerminalResistance=50ohm
  P3_BGA_N_T1: Terminal port=P3_BGA_N Faces=N_Ball.face(-z end) TerminalResistance=50ohm
  P1: Wave Port Faces=Port_Sheet_Cu1.face WavePortType=Terminal NumModes=1
  P2_BGA_P: Lumped Port Faces=P_Port_Sheet_BGA.face(at (-0.25, 0, -1.26)) LumpedPortType=Terminal Impedance=50ohm
  P3_BGA_N: Lumped Port Faces=N_Port_Sheet_BGA.face(at (0.25, 0, -1.26)) LumpedPortType=Terminal Impedance=50ohm
  reference conductors: BGA_GND_Sheet
setups:
  Setup1: HfssDriven Frequency=56GHz MaxDeltaS=0.02 MaximumPasses=20 MinimumPasses=1 MinimumConvergedPasses=1 PercentRefinement=30 BasisOrder=-1 PortAccuracy=2 DrivenSolverType="Direct Solver"
source amplitudes:
  P1:1: 1V 0deg
  P1:2, P2_BGA_P:1, P3_BGA_N:1: 0V 0deg
